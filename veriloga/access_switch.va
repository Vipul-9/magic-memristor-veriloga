// Ideal access transistor for 1T1R cells (gate g, channel a-b).
// Replace by a PDK NMOS (e.g. gpdk045 nmos1v) for the final Virtuoso runs.
`include "constants.vams"
`include "disciplines.vams"
module access_switch(a, b, g);
  inout a, b; input g;
  electrical a, b, g;
  parameter real Ron  = 50;
  parameter real Roff = 1e12;
  parameter real vth  = 0.5;
  parameter real k    = 40;
  real s;
  analog begin
    s = 0.5 * (1 + tanh(k * (V(g) - vth)));
    I(a, b) <+ V(a, b) * (s / Ron + (1 - s) / Roff);
  end
endmodule
