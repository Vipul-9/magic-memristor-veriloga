// Tri-state line driver for crossbar rows/columns.
// en > 0.5 V : out is driven to V(vin) through Ron
// en < 0.5 V : out is high-impedance (Roff)  -> line is FLOATING (paper's 'x')
`include "constants.vams"
`include "disciplines.vams"
module line_driver(out, vin, en);
  inout out; input vin, en;
  electrical out, vin, en;
  parameter real Ron  = 10;
  parameter real Roff = 1e12;
  parameter real k    = 40;            // smoothness of enable
  real s;
  analog begin
    s = 0.5 * (1 + tanh(k * (V(en) - 0.5)));
    I(out, vin) <+ V(out, vin) * (s / Ron + (1 - s) / Roff);
  end
endmodule
